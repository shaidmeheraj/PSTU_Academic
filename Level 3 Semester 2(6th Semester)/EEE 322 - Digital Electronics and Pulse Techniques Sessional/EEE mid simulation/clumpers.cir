* C:\Users\sharafat\Documents\clumpers.sch

* Schematics Version 9.1 - Web Update 1
* Wed Apr 01 16:25:00 2026

** Analysis setup **
.tran 0ns 10
.OP

* From [PSPICE NETLIST] section of pspiceev.ini:
.lib "nom.lib"

.INC "clumpers.net"
.INC "clumpers.als"

.probe

.END
