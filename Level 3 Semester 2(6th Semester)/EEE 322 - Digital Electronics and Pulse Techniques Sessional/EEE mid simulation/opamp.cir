* C:\Users\sharafat\Documents\opamp.sch

* Schematics Version 9.1 - Web Update 1
* Thu Apr 02 03:45:37 2026

** Analysis setup **
.tran 0ns 0.2s
.OP

* From [PSPICE NETLIST] section of pspiceev.ini:
.lib "nom.lib"

.INC "opamp.net"
.INC "opamp.als"

.probe

.END
